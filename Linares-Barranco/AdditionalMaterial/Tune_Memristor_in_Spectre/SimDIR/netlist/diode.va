// VerilogA for diode, veriloga

`include "discipline.h"
`include "constants.h"

module diode_simple(vp, vn);
inout vp, vn;
electrical vp, vn;
parameter real is = 1e-12 from (0:inf);

   real vd;

   analog begin
      vd = V(vp, vn);
      I(vp,vn) <+ is * (limexp(vd/0.026) - 1);
   end
endmodule
