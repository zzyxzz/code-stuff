// Design: memr/stdp_analysis2_r
simulator lang=spectre
global 0
parameters VBpre=-0.5 VBpos=-0.5 VApre=1 VApos=1 tr=1e-4 tf=1e-4 t2=2e-2 t1=1e-3 Tperiod2=220.4395102m Tperiod=200m TDpre=2.5m TDpos=3.5m Vtn=-1 Vtp=1 alpha=0 Cr=50m betan=1 betap=1 vlim=100 Rmin=10e6 Rmax=100M
inline subckt MULT v1 v2 out
R1 v1 0 resistor r=1000G
R2 v2 0 resistor r=1000G
E1 ( out 0 v1 0 v2 0 ) pvcvs coeffs=[0 0 0 0 1 ]
ends MULT

// memr/vcR/schematic
subckt vcR R rn rp
    R1 (rp net024) resistor r=1e-6
    R0 (net012 rn) resistor r=1e-6
    R2 (net030 net020) resistor r=1e-6
    E0 (net18 0) ccvs rm=1e6 probe=V0
    V0 (net020 net012) vsource dc=0 type=dc
    G1 (net024 net030 net21 0) vcvs gain=1.0
    G0 (R net18 net21) MULT
ends vcR

// memr/b_memr2/schematic
subckt b_memr2 R rn rp vinit
parameters _par0
    I36 (net036 net034) diode_simple
    I35 (net035 net036) diode_simple
    I30 (rp rn net022 net054) memr_f vth=1.0 vo=0.10 Io=1e-5
    W0 (net045 vinit net031 0) relay ropen=1T rclosed=1.0
    V0 (net031 0) vsource type=pwl wave=[ 1u 5 2u 0 ]
    E0 (R net042 net028 0) vcvs gain=(Rmax-Rmin)/20e6
    C0 (net045 0) capacitor c=_par0
    I6 (R net025 rp) vcR
    V5 (net034 0) vsource dc=9 type=dc
    V4 (net035 0) vsource dc=-9 type=dc
    V12 (net025 rn) vsource dc=0 type=dc
    V7 (net022 net028) vsource dc=0 type=dc
    V8 (net028 net036) vsource dc=0 type=dc
    V11 (net054 0) vsource dc=0 type=dc
    V6 (net028 net045) vsource dc=0 type=dc
    V10 (net042 0) vsource dc=(Rmax+Rmin)/2e6 type=dc
ends b_memr2

// memr/stdp_analysis2_r/schematic
I0 (stdp_3 stdp_1 stdp_2 net012) b_memr2 _par0=Cr
E0 (vstim 0 pre 0) vcvs gain=1
E1 (stdp_1 0 pos 0) vcvs gain=0.970
V10 (pos 0) vsource type=pwl delay=TDpos pwlperiod=Tperiod2 wave=[ 0 0 10.0u VApos 510.0u VApos 520.0u VBpos 68m 0 ]
V9 (pre 0) vsource type=pwl delay=TDpre pwlperiod=Tperiod wave=[ 0 0 10.0u VApre 510.0u VApre 520.0u VBpre 68m 0 ]
V5 (net012 0) vsource dc=-5 type=dc
V1 (vstim stdp_2) vsource dc=0 type=dc
simulatorOptions options reltol=100e-6 temp=27 homotopy=all limit=delta compatible=spice2
tran tran stop=1000 errpreset=conservative
save stdp_1 stdp_2 stdp_3
ahdl_include "diode.va"
ahdl_include "memr_f.va"
